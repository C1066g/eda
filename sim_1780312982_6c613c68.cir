* Audio Limiter v6 - Balanced compressor
* Target: gentle limiting, 1Vpk input → ~0.6Vpk output (4:1 ratio)

Vin in 0 SIN(0 1.0 1k)

* ---- Signal Path ----
Ebuf sig_in 0 in 0 1
Rfix sig_in att_out 1k

* Shunt: R = 10 + 100k * max(0, 1-ctrl)^2
* ctrl=0: R≈100k (no attn), ctrl=1: R=10 (-40dB)
Gshunt att_out 0 VALUE = { V(att_out) / (50 + 100000*(1-V(ctrl)+1e-9)*(1-V(ctrl)+1e-9)) }

Eout out 0 att_out 0 1

* ---- RMS Envelope Detector ----
Bpwr sqr 0 V = V(out) * V(out)
Datt sqr env_in IDEAL
R_att env_in env 1000
Cenv env 0 4.7u
R_rel env 0 22k
Bamp amp 0 V = SQRT(V(env))

* ---- Error Amplifier (gain=3, threshold=0.35V RMS ≈ 0.5Vpk) ----
Eerr err 0 VALUE = { LIMIT(0, 3*(V(amp)-0.35), 1) }

* ---- Control Filter ----
R_ctrl err ctrl 1k
C_ctrl ctrl 0 1u

.model IDEAL D(Is=1e-14 N=0.01 Rs=1m)
.tran 0.02m 50m

.control
run
.endc

.end
