* RC Low-Pass Filter Test
V1 in 0 AC 1 SIN(0 1 1k)
R1 in out 1k
C1 out 0 100n

.ac dec 100 1 1Meg
.tran 0.01m 5m
.end
