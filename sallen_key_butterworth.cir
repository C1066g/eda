* Sallen-Key Butterworth LPF — fc=1kHz, Q=0.7071
* R1=R2=15.9k, C1=20nF, C2=10nF  → fc=1/(2π·15.9k·sqrt(200e-18)) ≈ 1kHz
* C1/C2=2 for Q=0.707 (unity-gain Butterworth)
V1 in 0 AC 1
R1 in n1 15.9k
R2 n1 n2 15.9k
C1 n2 out 20n
C2 n1 0 10n
E1 out 0 n2 out 1e6
.ac dec 100 10 100k
.end
