* RC Low-Pass Filter - Transient Analysis
V1 in 0 SIN(0 1 1k)
R1 in out 1k
C1 out 0 100n

.tran 0.01m 5m
.end
