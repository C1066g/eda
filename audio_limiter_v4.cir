* Audio Limiter / Compressor - v4
*
* Working principle:
* 1. Envelope detector measures output amplitude
* 2. When envelope > threshold, control voltage rises (0 to 1)
* 3. Control voltage reduces shunt resistance → more attenuation
* 4. Feedback loop: attenuation → lower output → lower envelope → equilibrium

Vin in 0 SIN(0 1.0 1k)

* ---- Signal Path ----
Ebuf sig_in 0 in 0 1

* Voltage-Controlled Attenuator
* R_shunt = 100 + 100k*(1-ctrl)^2
* ctrl=0 (no limiting): R_shunt ≈ 100k → gain ≈ 1
* ctrl=1 (max limiting): R_shunt ≈ 100Ω → gain ≈ 0.09 (-21dB)
Rfix sig_in att_out 1k
Gshunt att_out 0 VALUE = { V(att_out) / (100 + 100000 * pow(LIMIT(0, 1-V(ctrl), 1), 2)) }

Eout out 0 att_out 0 1

* ---- Side-Chain: RMS Envelope Detector ----
* Square the signal
Bpwr sqr 0 V = V(out) * V(out)

* Peak-hold via ideal diode + RC
Datt sqr env_in IDEAL
R_att env_in env 100
Cenv env 0 10u
R_rel env 0 100k

* Linear envelope (RMS)
Bamp amp 0 V = SQRT(V(env))

* ---- Error Amplifier ----
* Threshold = 0.5V (envelope level)
* Output clamped to [0, 1]
Eerr err 0 VALUE = { LIMIT(0, V(amp) - 0.5, 1) }

* ---- Control Voltage Filter ----
R_ctrl err ctrl 1k
C_ctrl ctrl 0 2.2u

* ---- Models ----
.model IDEAL D(Is=1e-14 N=0.01 Rs=1m)

* ---- Analysis ----
.tran 0.01m 50m

.control
run
.endc

.end
