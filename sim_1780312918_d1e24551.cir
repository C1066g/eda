* Audio Limiter v5 - Fixed amplitude with aggressive limiting

Vin in 0 SIN(0 1.0 1k)

* ---- Signal Path ----
Ebuf sig_in 0 in 0 1

* Voltage-Controlled Attenuator
Rfix sig_in att_out 1k
* Shunt: R = 10 + 200k*(max(0.001, 1-ctrl))^3
* ctrl=0 → R≈200k (no attn), ctrl=1 → R=10 (max attn)
Gshunt att_out 0 VALUE = { V(att_out) / (10 + 200000 * (1-V(ctrl)+1e-9)*(1-V(ctrl)+1e-9)*(1-V(ctrl)+1e-9)) }

Eout out 0 att_out 0 1

* ---- RMS Envelope Detector ----
Bpwr sqr 0 V = V(out) * V(out)
Datt sqr env_in IDEAL
R_att env_in env 100
Cenv env 0 22u
R_rel env 0 100k
Bamp amp 0 V = SQRT(V(env))

* ---- Error Amplifier (gain=5, threshold=0.4V) ----
Eerr err 0 VALUE = { LIMIT(0, 5*(V(amp)-0.4), 1) }

* ---- Control Filter (faster response) ----
R_ctrl err ctrl 1k
C_ctrl ctrl 0 1u

* ---- Models ----
.model IDEAL D(Is=1e-14 N=0.01 Rs=1m)

.tran 0.02m 50m

.control
run
.endc

.end
